* Boost Converter Circuit for PROJECT_WOWKISPICE Co-Simulation
* Input: 3.3V DC (e.g. Li-ion / Battery input)
* Target Regulated Output: 5.0V DC (Hysteretic closed-loop control)
* Switch: Low-side Switch S1 driven by external gate source Vgate

Vin in 0 DC 3.3
Vgate gate 0 dc 0 external

* Inductor from input to switch node
L1 in sw_node 22u IC=0

* Low-side switch to ground
S1 sw_node 0 gate 0 SW_MODEL

* Diode to output capacitor and load
D1 sw_node vout DIODE_MODEL
C1 vout 0 47u IC=0
Rload vout 0 10.0

* Models
.model SW_MODEL SW(Ron=0.02 Roff=1e6 Vt=1.65 Vh=0.05)
.model DIODE_MODEL D(IS=1e-9 RS=0.01 N=1.0 BV=50 IBV=1e-4)

.tran 0.5u 5m uic
.end
